.title Malformed Include - Bug 7
R1 in out 1k
C1 out gnd 1p
V1 in gnd 1.8
.tran 10p 10n
.end
