.title Voltage Divider - Bug 4
R1 in mid 1k
R2 mid gnd 1k
V1 in gnd 5
.op
.end
