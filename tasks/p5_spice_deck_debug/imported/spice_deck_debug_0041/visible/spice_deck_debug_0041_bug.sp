.title RC Circuit - Duplicate Element
R1 in out 10k
C1 out gnd 10p
C1 out2 gnd 10p
R2 out2 gnd 10k
V1 in gnd PULSE(0 3.3 1n 100p 100p 2n 4n)
.tran 10p 10n
.end
