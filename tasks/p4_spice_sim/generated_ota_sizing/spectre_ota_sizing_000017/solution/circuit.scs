// Two-stage Miller OTA - sizing task (open-loop AC gain test rig)
simulator lang=spectre
global 0

// --- TUNABLE KNOBS (edit ONLY these two values) ---
parameters ibias=2.84628e-05 cc=2.424e-12

// Supplies and bias
vdd   (vdd 0)   vsource dc=3.3
itail (tail 0)  isource dc=ibias
vbias (vb 0)    vsource dc=2.2617

// Open-loop AC rig: lfb shorts DC (sets bias point), cfb grounds inn at AC
vin (inp 0) vsource dc=1.2 mag=1
lfb (out inn) inductor l=1e9
cfb (inn 0)   capacitor c=1e9

// Stage 1: NMOS diff pair (m1/m2) + PMOS mirror load (m3/m4).
// inn (feedback node) drives m1 (mirror/diode side) and the AC input inp drives
// m2 (output side): with the CS stage inverting, this makes `out` INVERTING w.r.t.
// inn, so the open-loop rig's out->inn feedback is NEGATIVE (stable DC bias). The
// opposite assignment latches the bias (positive feedback -> zero measured gain).
m1 (n1   inn tail tail) nch w=3e-05 l=1e-06
m2 (out1 inp tail tail) nch w=3e-05 l=1e-06
m3 (n1   n1  vdd  vdd)  pch w=1.5e-05 l=1e-06
m4 (out1 n1  vdd  vdd)  pch w=1.5e-05 l=1e-06

// Stage 2: CS NMOS (m6) + PMOS current-source load (m7) + Miller cap + load cap
m6 (out out1 0   0)   nch w=0.0001 l=1e-06
m7 (out vb   vdd vdd) pch w=0.0001 l=1e-06
cc1 (out1 out) capacitor c=cc
cl  (out 0)    capacitor c=5e-12

// Self-contained generic level-1 MOS models (no PDK dependency)
model nch mos1 type=n vto=0.7  kp=120u lambda=0.04 gamma=0.4 phi=0.7
model pch mos1 type=p vto=-0.8 kp=40u  lambda=0.06 gamma=0.5 phi=0.7

ac1 ac start=1 stop=1e10 dec=30
save out
