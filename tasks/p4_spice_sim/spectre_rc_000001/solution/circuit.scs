// RC low-pass filter - Spectre netlist (solution)
// Fixed: R=1.2k gives tdrise ~12ns within [8ns, 15ns] range

simulator lang=spectre
global 0

// Power supply
vdd (vdd 0) vsource type=dc dc=1.8

// Input pulse: 0V to 1.8V, 500ps rise/fall, 100ns pulse width, 200ns period
vin (in 0) vsource type=pulse val0=0 val1=1.8 delay=1n rise=500p fall=500p width=100n period=200n

// RC low-pass filter (FIXED: R=1.2k)
r1 (in out) resistor r=1.2k
c1 (out 0) capacitor c=10p

// Analysis
tran tran stop=150n errpreset=moderate

// Save outputs
save in out
