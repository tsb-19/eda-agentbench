// RC low-pass filter - Spectre netlist
// Buggy: R value too large, causing slow rise/fall times

simulator lang=spectre
global 0

// Power supply
vdd (vdd 0) vsource type=dc dc=1.8

// Input pulse: 0V to 1.8V, 500ps rise/fall, 100ns pulse width, 200ns period
vin (in 0) vsource type=pulse val0=0 val1=1.8 delay=1n rise=500p fall=500p width=100n period=200n

// RC low-pass filter (BUGGY: R=10k is too large)
r1 (in out) resistor r=10k
c1 (out 0) capacitor c=10p

// Analysis
tran tran stop=150n errpreset=moderate

// Save outputs
save in out
