// RC low-pass filter - Spectre netlist
simulator lang=spectre
global 0

// Power supply
vdd (vdd 0) vsource type=dc dc=1.8

// Input pulse
vin (in 0) vsource type=pulse val0=0 val1=1.8 delay=1n rise=500p fall=500p width=100n period=200n

// RC low-pass filter
r1 (in out) resistor r=2.2k
c1 (out 0) capacitor c=4.7p

// Analysis
tran tran stop=150n errpreset=moderate

// Save outputs
save in out
