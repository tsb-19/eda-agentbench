// RLC damping design - Spectre netlist (output across C)
simulator lang=spectre
global 0

// Fast voltage step on `in` (edge << circuit natural period -> ideal step)
vin (in 0) vsource type=pulse val0=0 val1=1.8 delay=1.01021e-08 rise=4.04083e-11 fall=4.04083e-11 width=1.61633e-06 period=3.23266e-06

// Series RLC. R1 is the damping resistor to size; L1 and C1 are FIXED.
l1 (in mid) inductor l=4.7e-06
r1 (mid out) resistor r=2129.01
c1 (out 0) capacitor c=2.2e-12

// Transient: maxstep resolves the ring, stop captures the settling tail
tran tran stop=8.08165e-07 errpreset=conservative maxstep=1.01021e-10

save in out
