.title Voltage Divider - Bug 4
* BUG: R1 is defined twice
R1 in mid 1k
R1 mid gnd 1k
V1 in gnd 5
.op
.end
