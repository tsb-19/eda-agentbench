.title Buffer Circuit - Missing Subckt
X1 in out buf
R1 out gnd 2.2k
V1 in gnd PULSE(0 3.3 1n 100p 100p 2n 4n)
.tran 10p 8n
.end
