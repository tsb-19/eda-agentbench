.title RC High-Pass - Duplicate Element
C1 in out 1p
R1 out gnd 1k
R2 in gnd 10k
V1 in gnd PULSE(0 1.8 1n 100p 100p 2n 4n)
.tran 10p 10n
.end
