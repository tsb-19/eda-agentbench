.title Voltage Divider - Duplicate Element
R1 in mid 4.7k
R1 mid gnd 10k
V1 in gnd 3.3
.op
.end
