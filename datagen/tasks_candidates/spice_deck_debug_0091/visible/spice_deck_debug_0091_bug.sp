.title Voltage Divider - Invalid Directive
.inc
R1 in mid 10k
R2 mid gnd 20k
V1 in gnd 12
.op
.end
