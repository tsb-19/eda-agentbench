.title RC Filter - Invalid Directive
R1 in out 10k
C1 out gnd 100f
V1 in gnd 3.3
.tran 10p 10n
.end
