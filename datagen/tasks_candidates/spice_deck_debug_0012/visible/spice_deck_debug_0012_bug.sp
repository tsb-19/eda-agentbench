.title Current Mirror - Missing Model
M1 ref ref gnd gnd nmos_bad W=2u L=180n
M2 out ref gnd gnd nmos_bad W=2u L=180n
R1 vdd ref 10k
Vdd vdd gnd 1.8
.op
.end
