.title Voltage Divider - Missing Include
.include component_lib.lib
R1 in mid 10k
R2 mid gnd 20k
V1 in gnd 12
.op
.end
